// importing libs
`include "discipline.h"
module diff_amp(
  output electrical out,
  input electrical in1,
  input electrical in2);
parameter real gain = 10; // setting gain to 10 of the differential amplifier
analog begin
    V(out) <+ gain * (V(in1, in2));
    // V(out) <+ 2 * atan( gain / 2 * V(in1, in2) );
end
endmodule
