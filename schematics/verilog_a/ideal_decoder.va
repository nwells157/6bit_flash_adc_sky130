`include "constants.vams"
`include "disciplines.vams"

module decoder_6bit(vdd, out5, out4, out3, out2, out1, out0, dec_in62, dec_in61, dec_in60, dec_in59, dec_in58, dec_in57, dec_in56, dec_in55, dec_in54, dec_in53, dec_in52, dec_in51, dec_in50, dec_in49, dec_in48, dec_in47, dec_in46, dec_in45, dec_in44, dec_in43, dec_in42, dec_in41, dec_in40, dec_in39, dec_in38, dec_in37, dec_in36, dec_in35, dec_in34, dec_in33, dec_in32, dec_in31, dec_in30, dec_in29, dec_in28, dec_in27, dec_in26, dec_in25, dec_in24, dec_in23, dec_in22, dec_in21, dec_in20, dec_in19, dec_in18, dec_in17, dec_in16, dec_in15, dec_in14, dec_in13, dec_in12, dec_in11, dec_in10, dec_in9, dec_in8, dec_in7, dec_in6, dec_in5, dec_in4, dec_in3, dec_in2, dec_in1, dec_in0, vss, vref

);

    input vdd, dec_in62, dec_in61, dec_in60, dec_in59, dec_in58, dec_in57, dec_in56, dec_in55, dec_in54, dec_in53, dec_in52, dec_in51, dec_in50, dec_in49, dec_in48, dec_in47, dec_in46, dec_in45, dec_in44, dec_in43, dec_in42, dec_in41, dec_in40, dec_in39, dec_in38, dec_in37, dec_in36, dec_in35, dec_in34, dec_in33, dec_in32, dec_in31, dec_in30, dec_in29, dec_in28, dec_in27, dec_in26, dec_in25, dec_in24, dec_in23, dec_in22, dec_in21, dec_in20, dec_in19, dec_in18, dec_in17, dec_in16, dec_in15, dec_in14, dec_in13, dec_in12, dec_in11, dec_in10, dec_in9, dec_in8, dec_in7, dec_in6, dec_in5, dec_in4, dec_in3, dec_in2, dec_in1, dec_in0, vss, vref;
    electrical vdd, dec_in62, dec_in61, dec_in60, dec_in59, dec_in58, dec_in57, dec_in56, dec_in55, dec_in54, dec_in53, dec_in52, dec_in51, dec_in50, dec_in49, dec_in48, dec_in47, dec_in46, dec_in45, dec_in44, dec_in43, dec_in42, dec_in41, dec_in40, dec_in39, dec_in38, dec_in37, dec_in36, dec_in35, dec_in34, dec_in33, dec_in32, dec_in31, dec_in30, dec_in29, dec_in28, dec_in27, dec_in26, dec_in25, dec_in24, dec_in23, dec_in22, dec_in21, dec_in20, dec_in19, dec_in18, dec_in17, dec_in16, dec_in15, dec_in14, dec_in13, dec_in12, dec_in11, dec_in10, dec_in9, dec_in8, dec_in7, dec_in6, dec_in5, dec_in4, dec_in3, dec_in2, dec_in1, dec_in0, vss, vref;

    output out0, out1, out2, out3, out4, out5;
    electrical out0, out1, out2, out3, out4, out5;

    parameter integer crash_fix = 0;
    integer code;
    real out5_value = 0;
    real out4_value = 0;
    real out3_value = 0;
    real out2_value = 0;
    real out1_value = 0;
    real out0_value = 0;

    analog begin
        // Code 63 - 111111
        if (V(dec_in62) > V(vdd)/2 ) begin
            out5_value = 1;
            out4_value = 1;
            out3_value = 1;
            out2_value = 1;
            out1_value = 1;
            out0_value = 1;

        // Code 62 - 111110
        end else if (V(dec_in61) > V(vdd)/2 ) begin
            out5_value = 1;
            out4_value = 1;
            out3_value = 1;
            out2_value = 1;
            out1_value = 1;
            out0_value = 0;

        // Code 61 - 111101
        end else if (V(dec_in60) > V(vdd)/2 ) begin
            out5_value = 1;
            out4_value = 1;
            out3_value = 1;
            out2_value = 1;
            out1_value = 0;
            out0_value = 1;

        // Code 60 - 111100
        end else if (V(dec_in59) > V(vdd)/2 ) begin
            out5_value = 1;
            out4_value = 1;
            out3_value = 1;
            out2_value = 1;
            out1_value = 0;
            out0_value = 0;

        // Code 59 - 111011
        end else if (V(dec_in58) > V(vdd)/2 ) begin
            out5_value = 1;
            out4_value = 1;
            out3_value = 1;
            out2_value = 0;
            out1_value = 1;
            out0_value = 1;

        // Code 58 - 111010
        end else if (V(dec_in57) > V(vdd)/2 ) begin
            out5_value = 1;
            out4_value = 1;
            out3_value = 1;
            out2_value = 0;
            out1_value = 1;
            out0_value = 0;

        // Code 57 - 111001
        end else if (V(dec_in56) > V(vdd)/2 ) begin
            out5_value = 1;
            out4_value = 1;
            out3_value = 1;
            out2_value = 0;
            out1_value = 0;
            out0_value = 1;

        // Code 56 - 111000
        end else if (V(dec_in55) > V(vdd)/2 ) begin
            out5_value = 1;
            out4_value = 1;
            out3_value = 1;
            out2_value = 0;
            out1_value = 0;
            out0_value = 0;

        // Code 55 - 110111
        end else if (V(dec_in54) > V(vdd)/2 ) begin
            out5_value = 1;
            out4_value = 1;
            out3_value = 0;
            out2_value = 1;
            out1_value = 1;
            out0_value = 1;

        // Code 54 - 110110
        end else if (V(dec_in53) > V(vdd)/2 ) begin
            out5_value = 1;
            out4_value = 1;
            out3_value = 0;
            out2_value = 1;
            out1_value = 1;
            out0_value = 0;

        // Code 53 - 110101
        end else if (V(dec_in52) > V(vdd)/2 ) begin
            out5_value = 1;
            out4_value = 1;
            out3_value = 0;
            out2_value = 1;
            out1_value = 0;
            out0_value = 1;

        // Code 52 - 110100
        end else if (V(dec_in51) > V(vdd)/2 ) begin
            out5_value = 1;
            out4_value = 1;
            out3_value = 0;
            out2_value = 1;
            out1_value = 0;
            out0_value = 0;

        // Code 51 - 110011
        end else if (V(dec_in50) > V(vdd)/2 ) begin
            out5_value = 1;
            out4_value = 1;
            out3_value = 0;
            out2_value = 0;
            out1_value = 1;
            out0_value = 1;

        // Code 50 - 110010
        end else if (V(dec_in49) > V(vdd)/2 ) begin
            out5_value = 1;
            out4_value = 1;
            out3_value = 0;
            out2_value = 0;
            out1_value = 1;
            out0_value = 0;

        // Code 49 - 110001
        end else if (V(dec_in48) > V(vdd)/2 ) begin
            out5_value = 1;
            out4_value = 1;
            out3_value = 0;
            out2_value = 0;
            out1_value = 0;
            out0_value = 1;

        // Code 48 - 110000
        end else if (V(dec_in47) > V(vdd)/2 ) begin
            out5_value = 1;
            out4_value = 1;
            out3_value = 0;
            out2_value = 0;
            out1_value = 0;
            out0_value = 0;

        // Code 47 - 101111
        end else if (V(dec_in46) > V(vdd)/2 ) begin
            out5_value = 1;
            out4_value = 0;
            out3_value = 1;
            out2_value = 1;
            out1_value = 1;
            out0_value = 1;

        // Code 46 - 101110
        end else if (V(dec_in45) > V(vdd)/2 ) begin
            out5_value = 1;
            out4_value = 0;
            out3_value = 1;
            out2_value = 1;
            out1_value = 1;
            out0_value = 0;

        // Code 45 - 101101
        end else if (V(dec_in44) > V(vdd)/2 ) begin
            out5_value = 1;
            out4_value = 0;
            out3_value = 1;
            out2_value = 1;
            out1_value = 0;
            out0_value = 1;

        // Code 44 - 101100
        end else if (V(dec_in43) > V(vdd)/2 ) begin
            out5_value = 1;
            out4_value = 0;
            out3_value = 1;
            out2_value = 1;
            out1_value = 0;
            out0_value = 0;

        // Code 43 - 101011
        end else if (V(dec_in42) > V(vdd)/2 ) begin
            out5_value = 1;
            out4_value = 0;
            out3_value = 1;
            out2_value = 0;
            out1_value = 1;
            out0_value = 1;

        // Code 42 - 101010
        end else if (V(dec_in41) > V(vdd)/2 ) begin
            out5_value = 1;
            out4_value = 0;
            out3_value = 1;
            out2_value = 0;
            out1_value = 1;
            out0_value = 0;

        // Code 41 - 101001
        end else if (V(dec_in40) > V(vdd)/2 ) begin
            out5_value = 1;
            out4_value = 0;
            out3_value = 1;
            out2_value = 0;
            out1_value = 0;
            out0_value = 1;

        // Code 40 - 101000
        end else if (V(dec_in39) > V(vdd)/2 ) begin
            out5_value = 1;
            out4_value = 0;
            out3_value = 1;
            out2_value = 0;
            out1_value = 0;
            out0_value = 0;

        // Code 39 - 100111
        end else if (V(dec_in38) > V(vdd)/2 ) begin
            out5_value = 1;
            out4_value = 0;
            out3_value = 0;
            out2_value = 1;
            out1_value = 1;
            out0_value = 1;

        // Code 38 - 100110
        end else if (V(dec_in37) > V(vdd)/2 ) begin
            out5_value = 1;
            out4_value = 0;
            out3_value = 0;
            out2_value = 1;
            out1_value = 1;
            out0_value = 0;

        // Code 37 - 100101
        end else if (V(dec_in36) > V(vdd)/2 ) begin
            out5_value = 1;
            out4_value = 0;
            out3_value = 0;
            out2_value = 1;
            out1_value = 0;
            out0_value = 1;

        // Code 36 - 100100
        end else if (V(dec_in35) > V(vdd)/2 ) begin
            out5_value = 1;
            out4_value = 0;
            out3_value = 0;
            out2_value = 1;
            out1_value = 0;
            out0_value = 0;

        // Code 35 - 100011
        end else if (V(dec_in34) > V(vdd)/2 ) begin
            out5_value = 1;
            out4_value = 0;
            out3_value = 0;
            out2_value = 0;
            out1_value = 1;
            out0_value = 1;

        // Code 34 - 100010
        end else if (V(dec_in33) > V(vdd)/2 ) begin
            out5_value = 1;
            out4_value = 0;
            out3_value = 0;
            out2_value = 0;
            out1_value = 1;
            out0_value = 0;

        // Code 33 - 100001
        end else if (V(dec_in32) > V(vdd)/2 ) begin
            out5_value = 1;
            out4_value = 0;
            out3_value = 0;
            out2_value = 0;
            out1_value = 0;
            out0_value = 1;

        // Code 32 - 100000
        end else if (V(dec_in31) > V(vdd)/2 ) begin
            out5_value = 1;
            out4_value = 0;
            out3_value = 0;
            out2_value = 0;
            out1_value = 0;
            out0_value = 0;

        // Code 31 - 011111
        end else if (V(dec_in30) > V(vdd)/2 ) begin
            out5_value = 0;
            out4_value = 1;
            out3_value = 1;
            out2_value = 1;
            out1_value = 1;
            out0_value = 1;

        // Code 30 - 011110
        end else if (V(dec_in29) > V(vdd)/2 ) begin
            out5_value = 0;
            out4_value = 1;
            out3_value = 1;
            out2_value = 1;
            out1_value = 1;
            out0_value = 0;

        // Code 29 - 011101
        end else if (V(dec_in28) > V(vdd)/2 ) begin
            out5_value = 0;
            out4_value = 1;
            out3_value = 1;
            out2_value = 1;
            out1_value = 0;
            out0_value = 1;

        // Code 28 - 011100
        end else if (V(dec_in27) > V(vdd)/2 ) begin
            out5_value = 0;
            out4_value = 1;
            out3_value = 1;
            out2_value = 1;
            out1_value = 0;
            out0_value = 0;

        // Code 27 - 011011
        end else if (V(dec_in26) > V(vdd)/2 ) begin
            out5_value = 0;
            out4_value = 1;
            out3_value = 1;
            out2_value = 0;
            out1_value = 1;
            out0_value = 1;

        // Code 26 - 011010
        end else if (V(dec_in25) > V(vdd)/2 ) begin
            out5_value = 0;
            out4_value = 1;
            out3_value = 1;
            out2_value = 0;
            out1_value = 1;
            out0_value = 0;

        // Code 25 - 011001
        end else if (V(dec_in24) > V(vdd)/2 ) begin
            out5_value = 0;
            out4_value = 1;
            out3_value = 1;
            out2_value = 0;
            out1_value = 0;
            out0_value = 1;

        // Code 24 - 011000
        end else if (V(dec_in23) > V(vdd)/2 ) begin
            out5_value = 0;
            out4_value = 1;
            out3_value = 1;
            out2_value = 0;
            out1_value = 0;
            out0_value = 0;

        // Code 23 - 010111
        end else if (V(dec_in22) > V(vdd)/2 ) begin
            out5_value = 0;
            out4_value = 1;
            out3_value = 0;
            out2_value = 1;
            out1_value = 1;
            out0_value = 1;

        // Code 22 - 010110
        end else if (V(dec_in21) > V(vdd)/2 ) begin
            out5_value = 0;
            out4_value = 1;
            out3_value = 0;
            out2_value = 1;
            out1_value = 1;
            out0_value = 0;

        // Code 21 - 010101
        end else if (V(dec_in20) > V(vdd)/2 ) begin
            out5_value = 0;
            out4_value = 1;
            out3_value = 0;
            out2_value = 1;
            out1_value = 0;
            out0_value = 1;

        // Code 20 - 010100
        end else if (V(dec_in19) > V(vdd)/2 ) begin
            out5_value = 0;
            out4_value = 1;
            out3_value = 0;
            out2_value = 1;
            out1_value = 0;
            out0_value = 0;

        // Code 19 - 010011
        end else if (V(dec_in18) > V(vdd)/2 ) begin
            out5_value = 0;
            out4_value = 1;
            out3_value = 0;
            out2_value = 0;
            out1_value = 1;
            out0_value = 1;

        // Code 18 - 010010
        end else if (V(dec_in17) > V(vdd)/2 ) begin
            out5_value = 0;
            out4_value = 1;
            out3_value = 0;
            out2_value = 0;
            out1_value = 1;
            out0_value = 0;

        // Code 17 - 010001
        end else if (V(dec_in16) > V(vdd)/2 ) begin
            out5_value = 0;
            out4_value = 1;
            out3_value = 0;
            out2_value = 0;
            out1_value = 0;
            out0_value = 1;

        // Code 16 - 010000
        end else if (V(dec_in15) > V(vdd)/2 ) begin
            out5_value = 0;
            out4_value = 1;
            out3_value = 0;
            out2_value = 0;
            out1_value = 0;
            out0_value = 0;

        // Code 15 - 001111
        end else if (V(dec_in14) > V(vdd)/2 ) begin
            out5_value = 0;
            out4_value = 0;
            out3_value = 1;
            out2_value = 1;
            out1_value = 1;
            out0_value = 1;

        // Code 14 - 001110
        end else if (V(dec_in13) > V(vdd)/2 ) begin
            out5_value = 0;
            out4_value = 0;
            out3_value = 1;
            out2_value = 1;
            out1_value = 1;
            out0_value = 0;

        // Code 13 - 001101
        end else if (V(dec_in12) > V(vdd)/2 ) begin
            out5_value = 0;
            out4_value = 0;
            out3_value = 1;
            out2_value = 1;
            out1_value = 0;
            out0_value = 1;

        // Code 12 - 001100
        end else if (V(dec_in11) > V(vdd)/2 ) begin
            out5_value = 0;
            out4_value = 0;
            out3_value = 1;
            out2_value = 1;
            out1_value = 0;
            out0_value = 0;

        // Code 11 - 001011
        end else if (V(dec_in10) > V(vdd)/2 ) begin
            out5_value = 0;
            out4_value = 0;
            out3_value = 1;
            out2_value = 0;
            out1_value = 1;
            out0_value = 1;

        // Code 10 - 001010
        end else if (V(dec_in9) > V(vdd)/2 ) begin
            out5_value = 0;
            out4_value = 0;
            out3_value = 1;
            out2_value = 0;
            out1_value = 1;
            out0_value = 0;

        // Code 9 - 001001
        end else if (V(dec_in8) > V(vdd)/2 ) begin
            out5_value = 0;
            out4_value = 0;
            out3_value = 1;
            out2_value = 0;
            out1_value = 0;
            out0_value = 1;

        // Code 8 - 001000
        end else if (V(dec_in7) > V(vdd)/2 ) begin
            out5_value = 0;
            out4_value = 0;
            out3_value = 1;
            out2_value = 0;
            out1_value = 0;
            out0_value = 0;

        // Code 7 - 000111
        end else if (V(dec_in6) > V(vdd)/2 ) begin
            out5_value = 0;
            out4_value = 0;
            out3_value = 0;
            out2_value = 1;
            out1_value = 1;
            out0_value = 1;

        // Code 6 - 000110
        end else if (V(dec_in5) > V(vdd)/2 ) begin
            out5_value = 0;
            out4_value = 0;
            out3_value = 0;
            out2_value = 1;
            out1_value = 1;
            out0_value = 0;

        // Code 5 - 000101
        end else if (V(dec_in4) > V(vdd)/2 ) begin
            out5_value = 0;
            out4_value = 0;
            out3_value = 0;
            out2_value = 1;
            out1_value = 0;
            out0_value = 1;

        // Code 4 - 000100
        end else if (V(dec_in3) > V(vdd)/2 ) begin
            out5_value = 0;
            out4_value = 0;
            out3_value = 0;
            out2_value = 1;
            out1_value = 0;
            out0_value = 0;

        // Code 3 - 000011
        end else if (V(dec_in2) > V(vdd)/2 ) begin
            out5_value = 0;
            out4_value = 0;
            out3_value = 0;
            out2_value = 0;
            out1_value = 1;
            out0_value = 1;

        // Code 2 - 000010
        end else if (V(dec_in1) > V(vdd)/2 ) begin
            out5_value = 0;
            out4_value = 0;
            out3_value = 0;
            out2_value = 0;
            out1_value = 1;
            out0_value = 0;

        // Code 1 - 000001
        end else if (V(dec_in0) > V(vdd)/2 ) begin
            out5_value = 0;
            out4_value = 0;
            out3_value = 0;
            out2_value = 0;
            out1_value = 0;
            out0_value = 1;
        end

        V(out5) <+ out5_value * V(vdd);
        V(out4) <+ out4_value * V(vdd);
        V(out3) <+ out3_value * V(vdd);
        V(out2) <+ out2_value * V(vdd);
        V(out1) <+ out1_value * V(vdd);
        V(out0) <+ out0_value * V(vdd);
    end
endmodule
